* 4-bits-lookahead netlist

.include 45nm_HP.model
.param lmin = 50n
.param wn = '2.5*lmin'
.param wp = '1.75*wn'
.param wn_x4 = '4*wn'
.param wp_x4 = '4*wp'

.subckt inv a not_a vdd vss
minv000 not_a a vdd vdd pmos l=lmin w=wp
minv001 not_a a vss vss nmos l=lmin w=wn
.ends inv

.subckt inv_x4 a not_a vdd vss
minv000 not_a a vdd vdd pmos l=lmin w=wp_x4
minv001 not_a a vss vss nmos l=lmin w=wn_x4
.ends inv_x4

.subckt and_2 a b vdd vss out
mand000 tmp a vdd vdd pmos l=lmin w=wp
mand001 tmp b vdd vdd pmos l=lmin w=wp
mand002 tmp a pd pd nmos l=lmin w=wn
mand003 pd b vss vss nmos l=lmin w=wn
mand004 out tmp vdd vdd pmos l=lmin w=wp
mand005 out tmp vss vss nmos l=lmin w=wp
.ends and_2

.subckt or_2 a b vdd vss out
mor000 pu a vdd vdd pmos l=lmin w=wp
mor001 tmp b pu pu pmos l=lmin w=wp
mor002 tmp a vss vss nmos l=lmin w=wn
mor003 tmp b vss vss nmos l=lmin w=wn
mor004 out tmp vdd vdd pmos l=lmin w=wp
mor005 out tmp vss vss nmos l=lmin w=wn
.ends or_2

.subckt xor_2 a b vdd vss out
mxor000 not_a a vdd vdd pmos l=lmin w=wp
mxor001 not_a a vss vss nmos l=lmin w=wn
mxor002 not_b b vdd vdd pmos l=lmin w=wp
mxor003 not_b b vss vss nmos l=lmin w=wn
mxor004 pu_l not_b vdd vdd pmos l=lmin w=wp
mxor005 out a pu_l pu_l pmos l=lmin w=wp
mxor006 out b pd_l pd_l nmos l=lmin w=wn
mxor007 pd_l a vss vss nmos l=lmin w=wn
mxor008 pu_r b vdd vdd pmos l=lmin w=wp
mxor009 out not_a pu_r pu_r pmos l=lmin w=wp
mxor010 out not_b pd_r pd_r nmos l=lmin w=wn
mxor011 pd_r not_a vss vss nmos l=lmin w=wn
.ends xor_2

.subckt and_3 a b c vdd vss out
xlogic000 a b vdd vss tmp and_2
xlogic001 tmp c vdd vss out and_2
.ends and_3

.subckt and_4 a b c d vdd vss out
xlogic000 a b c vdd vss tmp and_3
xlogic001 tmp d vdd vss out and_2
.ends and_4

.subckt and_5 a b c d e vdd vss out
xlogic000 a b c d vdd vss tmp and_4
xlogic001 tmp e vdd vss out and_2
.ends and_5

.subckt or_3 a b c vdd vss out
xlogic000 a b vdd vss a_b or_2
xlogic001 a_b c vdd vss out or_2
.ends or_3

.subckt or_4 a b c d vdd vss out
xlogic000 a b c vdd vss tmp or_3
xlogic002 tmp d vdd vss out or_2
.ends or_4

.subckt or_5 a b c d e vdd vss out
xlogic000 a b c d vdd vss tmp or_4
xlogic001 tmp e vdd vss out or_2
.ends or_5

.subckt ahead_adder a b c_in vdd vss s p g
xlogic000 a b vdd vss g and_2
xlogic001 a b vdd vss p xor_2
xlogic002 c_in p vdd vss s xor_2
.ends ahead_adder

.subckt lookahead_generator c_0 g_0 p_0 g_1 p_1 g_2 p_2 g_3 p_3 vdd vss c_1 c_2 c_3 c_4
xlogic000 p_0 c_0 vdd vss tmp_0 and_2
xlogic001 g_0 tmp_0 vdd vss c_1 or_2
xlogic002 p_1 g_0 vdd vss tmp_1 and_2
xlogic003 p_1 p_0 c_0 vdd vss tmp_2 and_3
xlogic004 g_1 tmp_1 tmp_2 vdd vss c_2 or_3
xlogic005 p_2 g_1 vdd vss tmp_3 and_2
xlogic006 p_2 p_1 g_0 vdd vss tmp_4 and_3
xlogic007 p_2 p_1 p_0 c_0 vdd vss tmp_5 and_4
xlogic008 g_2 tmp_3 tmp_4 tmp_5 vdd vss c_3 or_4
xlogic009 p_3 g_2 vdd vss tmp_6 and_2
xlogic010 p_3 p_2 g_1 vdd vss tmp_7 and_3
xlogic011 p_3 p_2 p_1 g_0 vdd vss tmp_8 and_4
xlogic012 p_3 p_2 p_1 p_0 c_0 vdd vss tmp_9 and_5
xlogic013 g_3 tmp_6 tmp_7 tmp_8 tmp_9 vdd vss c_4 or_5
.ends lookahead_generator

.subckt 4_bit_lookahead a_0 b_0 a_1 b_1 a_2 b_2 a_3 b_3 c_in vdd vss s_0 s_1 s_2 s_3 c_out
xlogic000 a_0 b_0 c_in vdd vss s_0 p_0 g_0 ahead_adder
xlogic001 a_1 b_1 c_1 vdd vss s_1 p_1 g_1 ahead_adder
xlogic002 a_2 b_2 c_2 vdd vss s_2 p_2 g_2 ahead_adder
xlogic003 a_3 b_3 c_3 vdd vss s_3 p_3 g_3 ahead_adder
xlogic004 c_in g_0 p_0 g_1 p_1 g_2 p_2 g_3 p_3 vdd vss c_1 c_2 c_3 c_out lookahead_generator
.ends 4_bit_lookahead

xdut a_out_0 a_out_1 a_out_2 a_out_3 b_out_0 b_out_1 b_out_2 b_out_3 c_in vdd vss s_out_0 s_out_1 s_out_2 s_out_3 c_out 4_bit_lookahead

v_a_in_0 a_in_0 0 dc 1
v_a_in_1 a_in_1 0 dc 0
v_a_in_2 a_in_2 0 dc 0
v_a_in_3 a_in_3 0 dc 0
v_b_in_0 b_in_0 0 dc 2
v_b_in_1 b_in_1 0 dc 0
v_b_in_2 b_in_2 0 dc 0
v_b_in_3 b_in_3 0 dc 0
v_c_in c_in 0 dc 0

v_supply_0 vdd 0 dc 1
v_supply_1 vdd_aux 0 dc 1
v_supply_2 vss 0 dc 0

.control
run
tran 1e-10 1e-9
plot v(s_out_0) xlimit 0 1e-9 ylimit -0.5 1.5
plot v(s_out_1) xlimit 0 1-9 ylimit -0.5 1.5
plot v(s_out_2) xlimit 0 1-9 ylimit -0.5 1.5
plot v(s_out_3) xlimit 0 1-9 ylimit -0.5 1.5
plot v(c_out) xlimit 0 1e-9 ylimit -0.5 1.5
.endc
