* nand-4 netlist

* the idea here was to use standard cells and boolean algebra to build an and-4 logic gate
* the a*b*c*d signal is generated from the boolean equation (a*b)*(c*d)
* eletric-test pwl sources generated with pwl_generator.py util

.include 45nm_HP.model
.param lmin = 50n
.param wn = '2.5*lmin'
.param wp = '1.75*wn'

.subckt and_2 a b vdd vss out
mand000 tmp a vdd vdd pmos l=lmin w=wp
mand001 tmp b vdd vdd pmos l=lmin w=wp
mand002 tmp a pd pd nmos l=lmin w=wn
mand003 pd b vss vss nmos l=lmin w=wn
mand004 out tmp vdd vdd pmos l=lmin w=wp
mand005 out tmp vss vss nmos l=lmin w=wp
.ends and_2

.subckt and_4 a b c d vdd vss out
xlogic000 a b vdd vss a_b and_2
xlogic001 c d vdd vss c_d and_2
xlogic002 a_b c_d vdd vss out and_2
.ends and_4

xand_4 in_0 in_1 in_2 in_3 vdd vss out_0 and_4

v_in_0 in_0 0 pwl(0 0 5e-09 0 5.01e-09 1 1e-08 1 1.001e-08 0 1.5000000000000002e-08 0 1.5010000000000003e-08 1 2e-08 1 2.0010000000000002e-08 0 2.5e-08 0 2.501e-08 1 3.0000000000000004e-08 1 3.001e-08 0 3.5e-08 0 3.501e-08 1 4e-08 1 4.001e-08 0 4.5e-08 0 4.501e-08 1 5e-08 1 5.0009999999999996e-08 0 5.5e-08 0 5.501e-08 1 6.000000000000001e-08 1 6.001e-08 0 6.5e-08 0 6.501e-08 1 7e-08 1 7.001e-08 0 7.5e-08 0 7.501e-08 1)
v_in_1 in_1 0 pwl(0 0 5e-09 0 5.01e-09 0 1e-08 0 1.001e-08 1 1.5000000000000002e-08 1 1.5010000000000003e-08 1 2e-08 1 2.0010000000000002e-08 0 2.5e-08 0 2.501e-08 0 3.0000000000000004e-08 0 3.001e-08 1 3.5e-08 1 3.501e-08 1 4e-08 1 4.001e-08 0 4.5e-08 0 4.501e-08 0 5e-08 0 5.0009999999999996e-08 1 5.5e-08 1 5.501e-08 1 6.000000000000001e-08 1 6.001e-08 0 6.5e-08 0 6.501e-08 0 7e-08 0 7.001e-08 1 7.5e-08 1 7.501e-08 1)
v_in_2 in_2 0 pwl(0 0 5e-09 0 5.01e-09 0 1e-08 0 1.001e-08 0 1.5000000000000002e-08 0 1.5010000000000003e-08 0 2e-08 0 2.0010000000000002e-08 1 2.5e-08 1 2.501e-08 1 3.0000000000000004e-08 1 3.001e-08 1 3.5e-08 1 3.501e-08 1 4e-08 1 4.001e-08 0 4.5e-08 0 4.501e-08 0 5e-08 0 5.0009999999999996e-08 0 5.5e-08 0 5.501e-08 0 6.000000000000001e-08 0 6.001e-08 1 6.5e-08 1 6.501e-08 1 7e-08 1 7.001e-08 1 7.5e-08 1 7.501e-08 1)
v_in_3 in_3 0 pwl(0 0 5e-09 0 5.01e-09 0 1e-08 0 1.001e-08 0 1.5000000000000002e-08 0 1.5010000000000003e-08 0 2e-08 0 2.0010000000000002e-08 0 2.5e-08 0 2.501e-08 0 3.0000000000000004e-08 0 3.001e-08 0 3.5e-08 0 3.501e-08 0 4e-08 0 4.001e-08 1 4.5e-08 1 4.501e-08 1 5e-08 1 5.0009999999999996e-08 1 5.5e-08 1 5.501e-08 1 6.000000000000001e-08 1 6.001e-08 1 6.5e-08 1 6.501e-08 1 7e-08 1 7.001e-08 1 7.5e-08 1 7.501e-08 1)

vdd vdd 0 dc 1
vss vss 0 dc 0

cap_out out_0 0 1e-18

.control
run
tran 1n 80n
plot v(in_0) xlimit 0 80e-9 ylimit -0.5 1.5
plot v(in_1) xlimit 0 80e-9 ylimit -0.5 1.5
plot v(in_2) xlimit 0 80e-9 ylimit -0.5 1.5
plot v(in_3) xlimit 0 80e-9 ylimit -0.5 1.5
plot v(out_0) xlimit 0 80e-9 ylimit -0.5 1.5
.endc
