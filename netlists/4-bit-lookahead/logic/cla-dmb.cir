* 4-bits-lookahead netlist
* design baseado no netlist apresentado em https://www.elprocus.com/carry-look-ahead-adder/

.include 45nm_HP.model
.param lmin = 50n
.param wn = '2.5*lmin'
.param wp = '1.75*wn'

.subckt inv a not_a vdd vss
minv000 not_a a vdd vdd pmos l=lmin w=wp
minv001 not_a a vss vss nmos l=lmin w=wn
.ends inv

.subckt nor_2 a b vdd vss out
mnor000 pu a vdd vdd pmos l=lmin w=wp
mnor001 out b pu pu pmos l=lmin w=wp
mnor002 out a vss vss nmos l=lmin w=wn
mnor003 out b vss vss nmos l=lmin w=wn
.ends nor_2

.subckt nand_2 a b vdd vss out
mnand000 out a vdd vdd pmos l=lmin w=wp
mnand001 out b vdd vdd pmos l=lmin w=wp
mnand002 out a pd pd nmos l=lmin w=wn
mnand003 pd b vss vss nmos l=lmin w=wn
.ends nand_2

.subckt and_2 a b vdd vss out
mand000 tmp a vdd vdd pmos l=lmin w=wp
mand001 tmp b vdd vdd pmos l=lmin w=wp
mand002 tmp a pd pd nmos l=lmin w=wn
mand003 pd b vss vss nmos l=lmin w=wn
mand004 out tmp vdd vdd pmos l=lmin w=wp
mand005 out tmp vss vss nmos l=lmin w=wp
.ends and_2

.subckt xor_2 a b vdd vss out
mxor000 not_a a vdd vdd pmos l=lmin w=wp
mxor001 not_a a vss vss nmos l=lmin w=wn
mxor002 not_b b vdd vdd pmos l=lmin w=wp
mxor003 not_b b vss vss nmos l=lmin w=wn
mxor004 pu_l not_b vdd vdd pmos l=lmin w=wp
mxor005 out a pu_l pu_l pmos l=lmin w=wp
mxor006 out b pd_l pd_l nmos l=lmin w=wn
mxor007 pd_l a vss vss nmos l=lmin w=wn
mxor008 pu_r b vdd vdd pmos l=lmin w=wp
mxor009 out not_a pu_r pu_r pmos l=lmin w=wp
mxor010 out not_b pd_r pd_r nmos l=lmin w=wn
mxor011 pd_r not_a vss vss nmos l=lmin w=wn
.ends xor_2

.subckt and_3 a b c vdd vss out
xlogic000 a b vdd vss tmp and_2
xlogic001 tmp c vdd vss out and_2
.ends and_3

.subckt and_4 a b c d vdd vss out
xlogic000 a b c vdd vss tmp and_3
xlogic001 tmp d vdd vss out and_2
.ends and_4

.subckt and_5 a b c d e vdd vss out
xlogic000 a b c d vdd vss tmp and_4
xlogic001 tmp e vdd vss out and_2
.ends and_5

.subckt or_2 a b vdd vss out
xlogic000 a b vdd vss tmp nor_2
xlogic001 tmp out vdd vss inv
.ends or_2

.subckt or_3 a b c vdd vss out
xlogic000 a b vdd vss tmp or_2
xlogic001 tmp c vdd vss out or_2
.ends or_3

.subckt or_4 a b c d vdd vss out
xlogic000 a b c vdd vss tmp or_3
xlogic001 tmp d vdd vss out or_2
.ends or_3

.subckt or_5 a b c d e vdd vss out
xlogic000 a b c d vdd vss tmp or_4
xlogic001 tmp e vdd vss out or_2
.ends or_5

.subckt nor_3 a b c vdd vss out
xlogic000 a b c vdd vss tmp or_3
xlogic001 tmp out vdd vss inv
.ends

.subckt nor_4 a b c d vdd vss out
xlogic000 a b c d vdd vss tmp or_4
xlogic001 tmp out vdd vss inv
.ends

.subckt nor_5 a b c d e vdd vss out
xlogic000 a b c d e vdd vss tmp or_5
xlogic001 tmp out vdd vss inv
.ends

.subckt not_adder a b vdd vss p g
xlogic000 a b vdd vss p nor_2
xlogic001 a b vdd vss g nand_2
.ends not_adder

.subckt lookahead c_in p_0 g_0 p_1 g_1 p_2 g_2 p_3 g_3 vdd vss s_0 s_1 s_2 s_3 c_out
xlogic000 c_in not_c_in vdd vss inv
xlogic001 p_0 not_p_0 vdd vss inv
xlogic002 p_1 not_p_1 vdd vss inv
xlogic003 p_2 not_p_2 vdd vss inv
xlogic004 p_3 not_p_3 vdd vss inv
xlogic005 not_c_in tmp_0 vdd vss inv
xlogic006 not_p_0 g_0 vdd vss tmp_1 and_2
xlogic007 not_c_in g_0 vdd vss tmp_2 and_2
xlogic008 not_p_1 g_1 vdd vss tmp_3 and_2
xlogic009 not_c_in g_0 g_1 vdd vss tmp_4 and_3
xlogic010 g_1 p_0 vdd vss tmp_5 and_2
xlogic011 not_p_2 g_2 vdd vss tmp_6 and_2
xlogic012 not_c_in g_0 g_1 g_2 vdd vss tmp_7 and_4
xlogic013 g_1 g_2 p_0 vdd vss tmp_8 and_3
xlogic014 g_2 p_1 vdd vss tmp_9 and_2
xlogic015 not_p_3 g_3 vdd vss tmp_10 and_2
xlogic016 not_c_in g_0 g_1 g_2 g_3 vdd vss tmp_11 and_5
xlogic017 g_1 g_2 g_3 p_0 vdd vss tmp_12 and_4
xlogic018 g_2 g_3 p_1 vdd vss tmp_13 and_3
xlogic019 g_3 p_2 vdd vss tmp_14 and_2
xlogic020 tmp_2 p_0 vdd vss tmp_15 nor_2
xlogic021 tmp_4 tmp_5 p_1 vdd vss tmp_16 nor_3
xlogic022 tmp_7 tmp_8 tmp_9 p_2 vdd vss tmp_17 nor_4
xlogic023 tmp_11 tmp_12 tmp_13 tmp_14 p_3 vdd vss c_out nor_5
xlogic024 tmp_0 tmp_1 vdd vss s_0 xor_2
xlogic025 tmp_15 tmp_3 vdd vss s_1 xor_2
xlogic026 tmp_16 tmp_6 vdd vss s_2 xor_2
xlogic027 tmp_17 tmp_10 vdd vss s_3 xor_2
.ends lookahead

.subckt 4_bit_lookahead c_in a_0 b_0 a_1 b_1 a_2 b_2 a_3 b_3 vdd vss s_0 s_1 s_2 s_3 c_out
xlogic000 a_0 b_0 vdd vss g_0 p_0 not_adder
xlogic001 a_1 b_1 vdd vss g_1 p_1 not_adder
xlogic002 a_2 b_2 vdd vss g_2 p_2 not_adder
xlogic003 a_3 b_3 vdd vss g_3 p_3 not_adder
xlogic004 c_in p_0 g_0 p_1 g_1 p_2 g_2 p_3 g_3 vdd vss s_0 s_1 s_2 s_3 c_out lookahead
.ends 4_bit_lookahead

xdus c_in a_in_0 a_in_1 a_in_2 a_in_3 b_in_0 b_in_1 b_in_2 b_in_3 vdd vss out_0 out_1 out_2 out_3 out_4 4_bit_lookahead

v_in_0 a_in_0 0 dc 1
v_in_1 a_in_1 0 dc 0
v_in_2 a_in_2 0 dc 0
v_in_3 a_in_3 0 dc 0
v_in_4 b_in_0 0 dc 1
v_in_5 b_in_1 0 dc 0
v_in_6 b_in_2 0 dc 0
v_in_7 b_in_3 0 dc 0
v_in_8 c_in 0 dc 0

v_supply_0 vdd 0 dc 1
v_supply_1 vss 0 dc 0

.control
run
tran 1e-10 1e-9
plot v(out_0) xlimit 0 4e-7 ylimit -0.5 1.5
plot v(out_1) xlimit 0 4e-7 ylimit -0.5 1.5
plot v(out_2) xlimit 0 4e-7 ylimit -0.5 1.5
plot v(out_3) xlimit 0 4e-7 ylimit -0.5 1.5
plot v(out_4) xlimit 0 4e-7 ylimit -0.5 1.5
.endc
