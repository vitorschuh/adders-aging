* sizing tunning

.include 45nm_HP.model
.param lmin = 45n
.param wn = '3.2*lmin'
.param wp = '2.5*wn'

.subckt inv a not_a vdd vss
minv000 not_a a vdd vdd pmos l=lmin w=wp
minv001 not_a a vss vss nmos l=lmin w=wn
.ends inv

xinv0 in_0 out_0 vdd vss inv
xinv1 in_1 out_1 vdd vss inv

vin_0 in_0 0 pwl(0 0 5e-9 0 5.01e-9 1)
vin_1 in_1 0 pwl(0 1 5e-9 1 5.01e-9 0)
vdd vdd 0 dc 1
vss vss 0 dc 0

c1 out_0 0 1e-18
c2 out_1 0 1e-18

.control
run
tran 1e-12 10e-9

let lmin = 45n
let wn = 3.2*lmin
let wp = 2.5*wn

meas tran t_hilo trig v(out_0) val={0.9*vdd} cross=1
    + targ v(out_0) val={0.1*vdd} cross=1
meas tran t_lohi trig v(out_1) val={0.1*vdd} cross=1
    + targ v(out_1) val={0.9*vdd} cross=1

print wn wp >> src/mosfet-sizing/logs/times/times.log
print t_hilo t_lohi >> src/mosfet-sizing/logs/times/times.log
print v(in_0) > src/mosfet-sizing/logs/raw/in_0.log
print v(in_1) > src/mosfet-sizing/logs/raw/in_1.log
print v(out_0) > src/mosfet-sizing/logs/raw/hi2lo.log
print v(out_1) > src/mosfet-sizing/logs/raw/lo2hi.log
.endc
